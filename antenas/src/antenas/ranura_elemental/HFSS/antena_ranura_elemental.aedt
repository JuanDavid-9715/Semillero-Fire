# Ansys Electronics Desktop project, version 2017.0
materials:
  vacuum: permittivity=1
  pec: conductivity=1e+030
  air: permittivity=1.0006 permeability=1.0000004

design DESIGN (HFSS, DrivenModal, model units mm)
variables:
  alto_puerto = 0.002m
  profundo_aire = 0.15m
  array = [327.8, 1500, 0.5, 800] mm
  placa = array[1]*array[0] m
  grosor_placa = array[2] m
  ancho_ranura = (array[0]/50) m
  alto_ranura = array[3]*array[0] m
  aire = 2*array[0] m
geometry:
  Box1 [pec] = box(corner=(0mm, -placa/2, -placa/2), size=(grosor_placa, placa, placa))
  Box2 = box(corner=(0mm, -ancho_ranura/2, -alto_ranura/2), size=(grosor_placa, ancho_ranura, alto_ranura))
  Box1.subtract(Box2)
  Box3 [air] = box(corner=(-profundo_aire/2, -aire/2, -aire/2), size=(profundo_aire, aire, aire))
  Rectangle1 = rectangle(corner=(0mm, -ancho_ranura/2, -alto_puerto/2), y_size=ancho_ranura, z_size=alto_puerto)
boundaries and excitations:
  Rad1: Radiation Objects=Box3
  1: Lumped Port Objects=Rectangle1 Modes{Mode1{IntLine{middle of Rectangle1.edge(y at corner) -> middle of Rectangle1.edge(y opposite corner)} CharImp=Zpi RenormImp=50ohm}} Impedance=50ohm
setups:
  Setup1: HfssDriven Frequency=2GHz MaxDeltaS=0.02 MaximumPasses=20 MinimumPasses=1 MinimumConvergedPasses=1 PercentRefinement=30 BasisOrder=1 PortAccuracy=2 RayDensityPerWavelength=4 MaxNumberOfBounces=5
    sweep Sweep: 500MHz to 1500MHz step 10MHz; Type=Fast SaveFields
source amplitudes:
  1:1: 1W 0deg
